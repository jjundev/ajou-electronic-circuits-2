* Vb1 sweep -> output CM
.include core.inc
Vb1 vb1 0 0.6
Vi1 in1 0 {VCM}
Vi2 in2 0 {VCM}
.control
dc Vb1 0.58 0.61 0.00001
wrdata tune.txt v(op)
.endc
.end
